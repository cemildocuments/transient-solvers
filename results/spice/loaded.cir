* Signed residual integrator, single-pole behavioural peripheral model
.options reltol=1e-8 abstol=1e-13 vntol=1e-10 method=gear
C0 x0 0 1.731581766040891e-14 IC=0.9683592267216361
I0 0 x0 6.021781354097993e-08
G0_0 x0 0 x0 0 8.245312652646642e-09
G0_1 x0 0 x1 0 -2.606528020655536e-09
G0_2 x0 0 x2 0 1.138750313739032e-09
G0_3 x0 0 x3 0 2.931066830227858e-09
G0_4 x0 0 x4 0 4.589581138043603e-09
G0_5 x0 0 x5 0 1.891354971858432e-08
G0_6 x0 0 x6 0 6.640303587885609e-09
G0_7 x0 0 x7 0 2.325156335823276e-08
G0_8 x0 0 x8 0 -1.983828082815539e-09
G0_9 x0 0 x9 0 1.274328812667509e-09
G0_10 x0 0 x10 0 -1.469136709755411e-09
G0_11 x0 0 x11 0 7.734924335209104e-10
G0_12 x0 0 x12 0 7.228358354331448e-09
G0_13 x0 0 x13 0 -2.657784782211872e-09
G0_14 x0 0 x14 0 2.460489184630509e-09
G0_15 x0 0 x15 0 -1.820837076871925e-09
C1 x1 0 2.198335144685083e-14 IC=0.9014180984631559
I1 0 x1 -4.807426893726873e-08
G1_0 x1 0 x0 0 -2.606528020655536e-09
G1_1 x1 0 x1 0 1.106342414958213e-07
G1_2 x1 0 x2 0 2.196272404698041e-09
G1_3 x1 0 x3 0 8.496395112021617e-09
G1_4 x1 0 x4 0 -1.18401272682005e-08
G1_5 x1 0 x5 0 -3.504618429290179e-08
G1_6 x1 0 x6 0 -2.477725312121822e-08
G1_7 x1 0 x7 0 -3.063021625249103e-09
G1_8 x1 0 x8 0 -1.025252469232641e-07
G1_9 x1 0 x9 0 -1.067208809965167e-08
G1_10 x1 0 x10 0 1.205434573065771e-08
G1_11 x1 0 x11 0 -1.086233465372673e-08
G1_12 x1 0 x12 0 -1.594249724959511e-08
G1_13 x1 0 x13 0 1.225905953837896e-08
G1_14 x1 0 x14 0 1.302285204933215e-08
G1_15 x1 0 x15 0 5.256260548809947e-09
C2 x2 0 1.871673892869011e-14 IC=0.898343587017555
I2 0 x2 9.75086024141025e-08
G2_0 x2 0 x0 0 1.138750313739032e-09
G2_1 x2 0 x1 0 2.196272404698041e-09
G2_2 x2 0 x2 0 2.471309000150816e-08
G2_3 x2 0 x3 0 3.165449458092952e-08
G2_4 x2 0 x4 0 2.658465632000665e-09
G2_5 x2 0 x5 0 1.184556248943764e-08
G2_6 x2 0 x6 0 -2.243007993444911e-10
G2_7 x2 0 x7 0 2.031862581628787e-08
G2_8 x2 0 x8 0 -2.548388852182019e-08
G2_9 x2 0 x9 0 1.230833139696239e-08
G2_10 x2 0 x10 0 3.157996431408684e-08
G2_11 x2 0 x11 0 -2.666770842252386e-10
G2_12 x2 0 x12 0 3.2928926399621e-09
G2_13 x2 0 x13 0 -1.5624995919398e-09
G2_14 x2 0 x14 0 -6.294883392367262e-09
G2_15 x2 0 x15 0 4.686913713097264e-10
C3 x3 0 2.505954217003113e-14 IC=0.8922936303202305
I3 0 x3 1.666487422421507e-07
G3_0 x3 0 x0 0 2.931066830227858e-09
G3_1 x3 0 x1 0 8.496395112021617e-09
G3_2 x3 0 x2 0 3.165449458092952e-08
G3_3 x3 0 x3 0 1.967601291794308e-07
G3_4 x3 0 x4 0 -1.588031341860796e-09
G3_5 x3 0 x5 0 -8.342437572487318e-09
G3_6 x3 0 x6 0 -1.483450761573747e-08
G3_7 x3 0 x7 0 4.595601835391338e-08
G3_8 x3 0 x8 0 -1.002881585525632e-07
G3_9 x3 0 x9 0 -5.981802484334464e-08
G3_10 x3 0 x10 0 5.489498643511891e-08
G3_11 x3 0 x11 0 -7.350521165386942e-09
G3_12 x3 0 x12 0 1.993905831434282e-08
G3_13 x3 0 x13 0 1.395907716264591e-09
G3_14 x3 0 x14 0 -2.464420166581272e-09
G3_15 x3 0 x15 0 1.782331389365739e-08
C4 x4 0 2.112928043300253e-14 IC=0.8904465551962552
I4 0 x4 9.285832094488166e-08
G4_0 x4 0 x0 0 4.589581138043603e-09
G4_1 x4 0 x1 0 -1.18401272682005e-08
G4_2 x4 0 x2 0 2.658465632000665e-09
G4_3 x4 0 x3 0 -1.588031341860796e-09
G4_4 x4 0 x4 0 9.46849353746512e-08
G4_5 x4 0 x5 0 5.51575867657765e-08
G4_6 x4 0 x6 0 8.51855975886477e-09
G4_7 x4 0 x7 0 -3.994264214610485e-08
G4_8 x4 0 x8 0 1.222737537511422e-11
G4_9 x4 0 x9 0 1.524278825730397e-08
G4_10 x4 0 x10 0 -4.787194581905036e-08
G4_11 x4 0 x11 0 1.136780758131663e-08
G4_12 x4 0 x12 0 -5.033101037993699e-09
G4_13 x4 0 x13 0 9.548727597019606e-09
G4_14 x4 0 x14 0 1.360319843973093e-08
G4_15 x4 0 x15 0 -5.932118145893162e-09
C5 x5 0 3.484026245733431e-14 IC=0.8603706676395809
I5 0 x5 8.869055009060284e-07
G5_0 x5 0 x0 0 1.891354971858432e-08
G5_1 x5 0 x1 0 -3.504618429290179e-08
G5_2 x5 0 x2 0 1.184556248943764e-08
G5_3 x5 0 x3 0 -8.342437572487318e-09
G5_4 x5 0 x4 0 5.51575867657765e-08
G5_5 x5 0 x5 0 7.429627338140752e-07
G5_6 x5 0 x6 0 1.943903004544138e-08
G5_7 x5 0 x7 0 -5.38137451100032e-08
G5_8 x5 0 x8 0 7.655397679288241e-08
G5_9 x5 0 x9 0 5.52695289828479e-08
G5_10 x5 0 x10 0 -4.611480594498493e-09
G5_11 x5 0 x11 0 1.466416047488784e-08
G5_12 x5 0 x12 0 4.195739415473249e-08
G5_13 x5 0 x13 0 2.095146280163958e-08
G5_14 x5 0 x14 0 1.101933280894518e-08
G5_15 x5 0 x15 0 1.853008528289422e-08
C6 x6 0 1.917549583654439e-14 IC=0.8821352594321012
I6 0 x6 2.205942917300026e-08
G6_0 x6 0 x0 0 6.640303587885609e-09
G6_1 x6 0 x1 0 -2.477725312121822e-08
G6_2 x6 0 x2 0 -2.243007993444911e-10
G6_3 x6 0 x3 0 -1.483450761573747e-08
G6_4 x6 0 x4 0 8.51855975886477e-09
G6_5 x6 0 x5 0 1.943903004544138e-08
G6_6 x6 0 x6 0 5.05441423669302e-08
G6_7 x6 0 x7 0 -1.422517564625059e-08
G6_8 x6 0 x8 0 2.887022371745245e-08
G6_9 x6 0 x9 0 -9.144355368600323e-10
G6_10 x6 0 x10 0 -8.754684747019965e-09
G6_11 x6 0 x11 0 -5.738879591722156e-09
G6_12 x6 0 x12 0 1.453963059740364e-10
G6_13 x6 0 x13 0 -7.377153191838293e-09
G6_14 x6 0 x14 0 5.135511371915697e-10
G6_15 x6 0 x15 0 -1.331433981085961e-08
C7 x7 0 4.189374981177509e-14 IC=0.8481229937733316
I7 0 x7 8.964842252700532e-07
G7_0 x7 0 x0 0 2.325156335823276e-08
G7_1 x7 0 x1 0 -3.063021625249103e-09
G7_2 x7 0 x2 0 2.031862581628787e-08
G7_3 x7 0 x3 0 4.595601835391338e-08
G7_4 x7 0 x4 0 -3.994264214610485e-08
G7_5 x7 0 x5 0 -5.381374511000321e-08
G7_6 x7 0 x6 0 -1.422517564625059e-08
G7_7 x7 0 x7 0 1e-06
G7_8 x7 0 x8 0 2.526675769214276e-08
G7_9 x7 0 x9 0 -1.579913560672633e-07
G7_10 x7 0 x10 0 1.755284699240487e-08
G7_11 x7 0 x11 0 3.871071228369552e-08
G7_12 x7 0 x12 0 1.222289841270619e-07
G7_13 x7 0 x13 0 -3.898224018454326e-08
G7_14 x7 0 x14 0 -1.006599380390342e-08
G7_15 x7 0 x15 0 2.089224959297105e-08
C8 x8 0 3.788226528293526e-14 IC=0.9114371324751119
I8 0 x8 6.256496586741453e-07
G8_0 x8 0 x0 0 -1.983828082815539e-09
G8_1 x8 0 x1 0 -1.025252469232641e-07
G8_2 x8 0 x2 0 -2.548388852182019e-08
G8_3 x8 0 x3 0 -1.002881585525632e-07
G8_4 x8 0 x4 0 1.222737537511422e-11
G8_5 x8 0 x5 0 7.655397679288241e-08
G8_6 x8 0 x6 0 2.887022371745245e-08
G8_7 x8 0 x7 0 2.526675769214276e-08
G8_8 x8 0 x8 0 8.098756489866218e-07
G8_9 x8 0 x9 0 -3.891044827956571e-08
G8_10 x8 0 x10 0 9.403430196017494e-08
G8_11 x8 0 x11 0 -5.72792650882683e-10
G8_12 x8 0 x12 0 3.076470325299883e-09
G8_13 x8 0 x13 0 -1.661752180904076e-08
G8_14 x8 0 x14 0 -2.160406259393481e-08
G8_15 x8 0 x15 0 -3.453737202034516e-08
C9 x9 0 3.126957531661539e-14 IC=0.8968223393023829
I9 0 x9 3.241003870263908e-07
G9_0 x9 0 x0 0 1.274328812667509e-09
G9_1 x9 0 x1 0 -1.067208809965167e-08
G9_2 x9 0 x2 0 1.230833139696239e-08
G9_3 x9 0 x3 0 -5.981802484334464e-08
G9_4 x9 0 x4 0 1.524278825730397e-08
G9_5 x9 0 x5 0 5.52695289828479e-08
G9_6 x9 0 x6 0 -9.144355368600325e-10
G9_7 x9 0 x7 0 -1.579913560672633e-07
G9_8 x9 0 x8 0 -3.891044827956571e-08
G9_9 x9 0 x9 0 5.146427686944908e-07
G9_10 x9 0 x10 0 -4.742969915981538e-09
G9_11 x9 0 x11 0 -3.486019714351061e-09
G9_12 x9 0 x12 0 5.238432137581317e-08
G9_13 x9 0 x13 0 -9.346527328727423e-09
G9_14 x9 0 x14 0 -1.642504059955382e-08
G9_15 x9 0 x15 0 1.129638400564765e-08
C10 x10 0 2.782145422034824e-14 IC=0.8996860720827129
I10 0 x10 5.100699143604932e-07
G10_0 x10 0 x0 0 -1.469136709755411e-09
G10_1 x10 0 x1 0 1.205434573065771e-08
G10_2 x10 0 x2 0 3.157996431408685e-08
G10_3 x10 0 x3 0 5.489498643511891e-08
G10_4 x10 0 x4 0 -4.787194581905036e-08
G10_5 x10 0 x5 0 -4.611480594498493e-09
G10_6 x10 0 x6 0 -8.754684747019965e-09
G10_7 x10 0 x7 0 1.755284699240487e-08
G10_8 x10 0 x8 0 9.403430196017491e-08
G10_9 x10 0 x9 0 -4.742969915981538e-09
G10_10 x10 0 x10 0 3.82111633202716e-07
G10_11 x10 0 x11 0 -1.046919078368527e-08
G10_12 x10 0 x12 0 3.687615783075801e-08
G10_13 x10 0 x13 0 1.863685618752917e-08
G10_14 x10 0 x14 0 -1.274517869359824e-08
G10_15 x10 0 x15 0 9.66784389957972e-09
C11 x11 0 1.882059828790892e-14 IC=0.8985904102974459
I11 0 x11 9.340967733973263e-08
G11_0 x11 0 x0 0 7.734924335209104e-10
G11_1 x11 0 x1 0 -1.086233465372673e-08
G11_2 x11 0 x2 0 -2.666770842252386e-10
G11_3 x11 0 x3 0 -7.350521165386942e-09
G11_4 x11 0 x4 0 1.136780758131663e-08
G11_5 x11 0 x5 0 1.466416047488784e-08
G11_6 x11 0 x6 0 -5.738879591722157e-09
G11_7 x11 0 x7 0 3.871071228369552e-08
G11_8 x11 0 x8 0 -5.72792650882683e-10
G11_9 x11 0 x9 0 -3.486019714351061e-09
G11_10 x11 0 x10 0 -1.046919078368527e-08
G11_11 x11 0 x11 0 6.266780643621787e-08
G11_12 x11 0 x12 0 3.008769125396918e-09
G11_13 x11 0 x13 0 6.543321105660309e-09
G11_14 x11 0 x14 0 -6.2585234187248e-10
G11_15 x11 0 x15 0 5.42472892263725e-09
C12 x12 0 2.346677320386093e-14 IC=0.8825704586958686
I12 0 x12 3.72211608958118e-07
G12_0 x12 0 x0 0 7.228358354331448e-09
G12_1 x12 0 x1 0 -1.594249724959511e-08
G12_2 x12 0 x2 0 3.292892639962101e-09
G12_3 x12 0 x3 0 1.993905831434282e-08
G12_4 x12 0 x4 0 -5.033101037993699e-09
G12_5 x12 0 x5 0 4.195739415473249e-08
G12_6 x12 0 x6 0 1.453963059740364e-10
G12_7 x12 0 x7 0 1.222289841270619e-07
G12_8 x12 0 x8 0 3.076470325299883e-09
G12_9 x12 0 x9 0 5.238432137581317e-08
G12_10 x12 0 x10 0 3.687615783075801e-08
G12_11 x12 0 x11 0 3.008769125396918e-09
G12_12 x12 0 x12 0 1.31541093250128e-07
G12_13 x12 0 x13 0 6.302238836349947e-09
G12_14 x12 0 x14 0 -9.470597520529868e-09
G12_15 x12 0 x15 0 1.603351556587685e-08
C13 x13 0 1.883933542976923e-14 IC=0.9065724978740733
I13 0 x13 2.756061172524192e-08
G13_0 x13 0 x0 0 -2.657784782211872e-09
G13_1 x13 0 x1 0 1.225905953837896e-08
G13_2 x13 0 x2 0 -1.5624995919398e-09
G13_3 x13 0 x3 0 1.395907716264592e-09
G13_4 x13 0 x4 0 9.548727597019606e-09
G13_5 x13 0 x5 0 2.095146280163958e-08
G13_6 x13 0 x6 0 -7.377153191838293e-09
G13_7 x13 0 x7 0 -3.898224018454326e-08
G13_8 x13 0 x8 0 -1.661752180904076e-08
G13_9 x13 0 x9 0 -9.346527328727423e-09
G13_10 x13 0 x10 0 1.863685618752917e-08
G13_11 x13 0 x11 0 6.543321105660309e-09
G13_12 x13 0 x12 0 6.302238836349947e-09
G13_13 x13 0 x13 0 2.315685785302275e-08
G13_14 x13 0 x14 0 1.611677940208287e-09
G13_15 x13 0 x15 0 6.760519229163672e-09
C14 x14 0 1.848798372570571e-14 IC=0.8921953148170729
I14 0 x14 2.017996940350486e-09
G14_0 x14 0 x0 0 2.460489184630509e-09
G14_1 x14 0 x1 0 1.302285204933215e-08
G14_2 x14 0 x2 0 -6.29488339236726e-09
G14_3 x14 0 x3 0 -2.464420166581272e-09
G14_4 x14 0 x4 0 1.360319843973094e-08
G14_5 x14 0 x5 0 1.101933280894517e-08
G14_6 x14 0 x6 0 5.135511371915697e-10
G14_7 x14 0 x7 0 -1.006599380390342e-08
G14_8 x14 0 x8 0 -2.160406259393482e-08
G14_9 x14 0 x9 0 -1.642504059955382e-08
G14_10 x14 0 x10 0 -1.274517869359824e-08
G14_11 x14 0 x11 0 -6.258523418724801e-10
G14_12 x14 0 x12 0 -9.470597520529868e-09
G14_13 x14 0 x13 0 1.611677940208287e-09
G14_14 x14 0 x14 0 3.28339206147586e-08
G14_15 x14 0 x15 0 6.873225760155616e-09
C15 x15 0 1.952598281796406e-14 IC=0.9063132788467815
I15 0 x15 1.040799144535099e-07
G15_0 x15 0 x0 0 -1.820837076871925e-09
G15_1 x15 0 x1 0 5.256260548809947e-09
G15_2 x15 0 x2 0 4.686913713097264e-10
G15_3 x15 0 x3 0 1.782331389365739e-08
G15_4 x15 0 x4 0 -5.932118145893162e-09
G15_5 x15 0 x5 0 1.853008528289422e-08
G15_6 x15 0 x6 0 -1.331433981085961e-08
G15_7 x15 0 x7 0 2.089224959297105e-08
G15_8 x15 0 x8 0 -3.453737202034516e-08
G15_9 x15 0 x9 0 1.129638400564765e-08
G15_10 x15 0 x10 0 9.667843899579719e-09
G15_11 x15 0 x11 0 5.42472892263725e-09
G15_12 x15 0 x12 0 1.603351556587685e-08
G15_13 x15 0 x13 0 6.760519229163673e-09
G15_14 x15 0 x14 0 6.873225760155615e-09
G15_15 x15 0 x15 0 5.222219837405561e-08
.control
set wr_vecnames
set wr_singlescale
tran 1.83354220622617e-09 1.466833764980936e-05 0 1.83354220622617e-09 uic
wrdata loaded.dat v(x0) v(x1) v(x2) v(x3) v(x4) v(x5) v(x6) v(x7) v(x8) v(x9) v(x10) v(x11) v(x12) v(x13) v(x14) v(x15)
quit
.endc
.end
